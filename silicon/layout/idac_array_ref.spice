* idac_array -- LVS reference, generated by idac_netlist.py
.subckt idac_array vss c_t0 c_t1 c_t2 c_t3 c_t4 c_t5 c_t6 c_t7 c_t8 c_t9 c_t10 c_t11 c_t12 c_t13 c_t14 c_b5 c_b4 c_b3 c_b2 c_b1 c_b0 c_o0 c_o1 c_o2 ibias dt0 dt1 dt2 dt3 dt4 dt5 dt6
XA_c_t0 c_t0 ibias vss vss sky130_fd_pr__nfet_01v8 W=0.84 L=24 m=64
XA_c_t1 c_t1 ibias vss vss sky130_fd_pr__nfet_01v8 W=0.84 L=24 m=64
XA_c_t2 c_t2 ibias vss vss sky130_fd_pr__nfet_01v8 W=0.84 L=24 m=64
XA_c_t3 c_t3 ibias vss vss sky130_fd_pr__nfet_01v8 W=0.84 L=24 m=64
XA_c_t4 c_t4 ibias vss vss sky130_fd_pr__nfet_01v8 W=0.84 L=24 m=64
XA_c_t5 c_t5 ibias vss vss sky130_fd_pr__nfet_01v8 W=0.84 L=24 m=64
XA_c_t6 c_t6 ibias vss vss sky130_fd_pr__nfet_01v8 W=0.84 L=24 m=64
XA_c_t7 c_t7 ibias vss vss sky130_fd_pr__nfet_01v8 W=0.84 L=24 m=64
XA_c_t8 c_t8 ibias vss vss sky130_fd_pr__nfet_01v8 W=0.84 L=24 m=64
XA_c_t9 c_t9 ibias vss vss sky130_fd_pr__nfet_01v8 W=0.84 L=24 m=64
XA_c_t10 c_t10 ibias vss vss sky130_fd_pr__nfet_01v8 W=0.84 L=24 m=64
XA_c_t11 c_t11 ibias vss vss sky130_fd_pr__nfet_01v8 W=0.84 L=24 m=64
XA_c_t12 c_t12 ibias vss vss sky130_fd_pr__nfet_01v8 W=0.84 L=24 m=64
XA_c_t13 c_t13 ibias vss vss sky130_fd_pr__nfet_01v8 W=0.84 L=24 m=64
XA_c_t14 c_t14 ibias vss vss sky130_fd_pr__nfet_01v8 W=0.84 L=24 m=64
XA_c_b5 c_b5 ibias vss vss sky130_fd_pr__nfet_01v8 W=0.84 L=24 m=32
XA_c_b4 c_b4 ibias vss vss sky130_fd_pr__nfet_01v8 W=0.84 L=24 m=16
XA_c_b3 c_b3 ibias vss vss sky130_fd_pr__nfet_01v8 W=0.84 L=24 m=8
XA_c_b2 c_b2 ibias vss vss sky130_fd_pr__nfet_01v8 W=0.84 L=24 m=4
XA_c_b1 c_b1 ibias vss vss sky130_fd_pr__nfet_01v8 W=0.84 L=24 m=2
XA_c_b0 c_b0 ibias vss vss sky130_fd_pr__nfet_01v8 W=0.84 L=24 m=1
XA_c_o0 c_o0 ibias vss vss sky130_fd_pr__nfet_01v8 W=0.84 L=24 m=64
XA_c_o1 c_o1 ibias vss vss sky130_fd_pr__nfet_01v8 W=0.84 L=24 m=64
XA_c_o2 c_o2 ibias vss vss sky130_fd_pr__nfet_01v8 W=0.84 L=24 m=26
XA_ibias ibias ibias vss vss sky130_fd_pr__nfet_01v8 W=0.84 L=24 m=64
XA_dt0 dt0 ibias vss vss sky130_fd_pr__nfet_01v8 W=0.84 L=24 m=1
XA_dt1 dt1 ibias vss vss sky130_fd_pr__nfet_01v8 W=0.84 L=24 m=2
XA_dt2 dt2 ibias vss vss sky130_fd_pr__nfet_01v8 W=0.84 L=24 m=4
XA_dt3 dt3 ibias vss vss sky130_fd_pr__nfet_01v8 W=0.84 L=24 m=8
XA_dt4 dt4 ibias vss vss sky130_fd_pr__nfet_01v8 W=0.84 L=24 m=16
XA_dt5 dt5 ibias vss vss sky130_fd_pr__nfet_01v8 W=0.84 L=24 m=32
XA_dt6 dt6 ibias vss vss sky130_fd_pr__nfet_01v8 W=0.84 L=24 m=64
* dummies: drain and source to vss, gate on the shared sheet
XA_dum vss ibias vss vss sky130_fd_pr__nfet_01v8 W=0.84 L=24 m=30
.ends
