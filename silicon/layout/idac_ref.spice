* idac -- LVS reference for layout/idac.gds, generated by idac_netlist.py
* Do not edit by hand: change idac_netlist.py and regenerate.

.subckt idac_array vss c_t0 c_t1 c_t2 c_t3 c_t4 c_t5 c_t6 c_t7 c_t8 c_t9 c_t10 c_t11 c_t12 c_t13 c_t14 c_b5 c_b4 c_b3 c_b2 c_b1 c_b0 c_o0 c_o1 c_o2 ibias dt0 dt1 dt2 dt3 dt4 dt5 dt6
XA_c_t0 c_t0 ibias vss vss sky130_fd_pr__nfet_01v8 W=0.84 L=24 m=64
XA_c_t1 c_t1 ibias vss vss sky130_fd_pr__nfet_01v8 W=0.84 L=24 m=64
XA_c_t2 c_t2 ibias vss vss sky130_fd_pr__nfet_01v8 W=0.84 L=24 m=64
XA_c_t3 c_t3 ibias vss vss sky130_fd_pr__nfet_01v8 W=0.84 L=24 m=64
XA_c_t4 c_t4 ibias vss vss sky130_fd_pr__nfet_01v8 W=0.84 L=24 m=64
XA_c_t5 c_t5 ibias vss vss sky130_fd_pr__nfet_01v8 W=0.84 L=24 m=64
XA_c_t6 c_t6 ibias vss vss sky130_fd_pr__nfet_01v8 W=0.84 L=24 m=64
XA_c_t7 c_t7 ibias vss vss sky130_fd_pr__nfet_01v8 W=0.84 L=24 m=64
XA_c_t8 c_t8 ibias vss vss sky130_fd_pr__nfet_01v8 W=0.84 L=24 m=64
XA_c_t9 c_t9 ibias vss vss sky130_fd_pr__nfet_01v8 W=0.84 L=24 m=64
XA_c_t10 c_t10 ibias vss vss sky130_fd_pr__nfet_01v8 W=0.84 L=24 m=64
XA_c_t11 c_t11 ibias vss vss sky130_fd_pr__nfet_01v8 W=0.84 L=24 m=64
XA_c_t12 c_t12 ibias vss vss sky130_fd_pr__nfet_01v8 W=0.84 L=24 m=64
XA_c_t13 c_t13 ibias vss vss sky130_fd_pr__nfet_01v8 W=0.84 L=24 m=64
XA_c_t14 c_t14 ibias vss vss sky130_fd_pr__nfet_01v8 W=0.84 L=24 m=64
XA_c_b5 c_b5 ibias vss vss sky130_fd_pr__nfet_01v8 W=0.84 L=24 m=32
XA_c_b4 c_b4 ibias vss vss sky130_fd_pr__nfet_01v8 W=0.84 L=24 m=16
XA_c_b3 c_b3 ibias vss vss sky130_fd_pr__nfet_01v8 W=0.84 L=24 m=8
XA_c_b2 c_b2 ibias vss vss sky130_fd_pr__nfet_01v8 W=0.84 L=24 m=4
XA_c_b1 c_b1 ibias vss vss sky130_fd_pr__nfet_01v8 W=0.84 L=24 m=2
XA_c_b0 c_b0 ibias vss vss sky130_fd_pr__nfet_01v8 W=0.84 L=24 m=1
XA_c_o0 c_o0 ibias vss vss sky130_fd_pr__nfet_01v8 W=0.84 L=24 m=64
XA_c_o1 c_o1 ibias vss vss sky130_fd_pr__nfet_01v8 W=0.84 L=24 m=64
XA_c_o2 c_o2 ibias vss vss sky130_fd_pr__nfet_01v8 W=0.84 L=24 m=26
XA_ibias ibias ibias vss vss sky130_fd_pr__nfet_01v8 W=0.84 L=24 m=64
XA_dt0 dt0 ibias vss vss sky130_fd_pr__nfet_01v8 W=0.84 L=24 m=1
XA_dt1 dt1 ibias vss vss sky130_fd_pr__nfet_01v8 W=0.84 L=24 m=2
XA_dt2 dt2 ibias vss vss sky130_fd_pr__nfet_01v8 W=0.84 L=24 m=4
XA_dt3 dt3 ibias vss vss sky130_fd_pr__nfet_01v8 W=0.84 L=24 m=8
XA_dt4 dt4 ibias vss vss sky130_fd_pr__nfet_01v8 W=0.84 L=24 m=16
XA_dt5 dt5 ibias vss vss sky130_fd_pr__nfet_01v8 W=0.84 L=24 m=32
XA_dt6 dt6 ibias vss vss sky130_fd_pr__nfet_01v8 W=0.84 L=24 m=64
* dummies: drain and source to vss, gate on the shared sheet
XA_dum vss ibias vss vss sky130_fd_pr__nfet_01v8 W=0.84 L=24 m=30
.ends

.subckt idac vdd vss ibias cbias outp outn d_t0 db_t0 d_t1 db_t1 d_t2 db_t2 d_t3 db_t3 d_t4 db_t4 d_t5 db_t5 d_t6 db_t6 d_t7 db_t7 d_t8 db_t8 d_t9 db_t9 d_t10 db_t10 d_t11 db_t11 d_t12 db_t12 d_t13 db_t13 d_t14 db_t14 d_b5 db_b5 d_b4 db_b4 d_b3 db_b3 d_b2 db_b2 d_b1 db_b1 d_b0 db_b0 trim0 trim1 trim2 trim3 trim4 trim5 trim6
* the unit array: output segments, reference diode, trim units, dummies
Xarr vss c_t0 c_t1 c_t2 c_t3 c_t4 c_t5 c_t6 c_t7 c_t8 c_t9 c_t10 c_t11 c_t12 c_t13 c_t14 c_b5 c_b4 c_b3 c_b2 c_b1 c_b0 c_o0 c_o1 c_o2 ibias dt0 dt1 dt2 dt3 dt4 dt5 dt6 idac_array
* load resistors: outp's carries the DAC current, outn's none -- it is
* vn's precharge path, matched so VDD noise cancels
XRp vdd outp vss sky130_fd_pr__res_high_po_2p85 L=16.43
XRn vdd outn vss sky130_fd_pr__res_high_po_2p85 L=16.43
* 7 b trim: each bit's units are diode-connected through a switch, so an
* unselected unit carries no current
XSt0 ibias trim0 dt0 vss sky130_fd_pr__nfet_01v8 W=0.42 L=0.15 m=1
XSt1 ibias trim1 dt1 vss sky130_fd_pr__nfet_01v8 W=0.42 L=0.15 m=1
XSt2 ibias trim2 dt2 vss sky130_fd_pr__nfet_01v8 W=0.42 L=0.15 m=1
XSt3 ibias trim3 dt3 vss sky130_fd_pr__nfet_01v8 W=0.42 L=0.15 m=1
XSt4 ibias trim4 dt4 vss sky130_fd_pr__nfet_01v8 W=0.42 L=0.15 m=1
XSt5 ibias trim5 dt5 vss sky130_fd_pr__nfet_01v8 W=0.42 L=0.15 m=1
XSt6 ibias trim6 dt6 vss sky130_fd_pr__nfet_01v8 W=0.42 L=0.15 m=1
* per segment: a switch pair steering it into outp or dumping it to VDD
XC_t0 s_t0 cbias c_t0 vss sky130_fd_pr__nfet_01v8 W=13.44 L=0.5 m=2
XP_t0 outp d_t0 s_t0 vss sky130_fd_pr__nfet_01v8 W=1.68 L=0.15 m=1
XN_t0 vdd db_t0 s_t0 vss sky130_fd_pr__nfet_01v8 W=1.68 L=0.15 m=1
XC_t1 s_t1 cbias c_t1 vss sky130_fd_pr__nfet_01v8 W=13.44 L=0.5 m=2
XP_t1 outp d_t1 s_t1 vss sky130_fd_pr__nfet_01v8 W=1.68 L=0.15 m=1
XN_t1 vdd db_t1 s_t1 vss sky130_fd_pr__nfet_01v8 W=1.68 L=0.15 m=1
XC_t2 s_t2 cbias c_t2 vss sky130_fd_pr__nfet_01v8 W=13.44 L=0.5 m=2
XP_t2 outp d_t2 s_t2 vss sky130_fd_pr__nfet_01v8 W=1.68 L=0.15 m=1
XN_t2 vdd db_t2 s_t2 vss sky130_fd_pr__nfet_01v8 W=1.68 L=0.15 m=1
XC_t3 s_t3 cbias c_t3 vss sky130_fd_pr__nfet_01v8 W=13.44 L=0.5 m=2
XP_t3 outp d_t3 s_t3 vss sky130_fd_pr__nfet_01v8 W=1.68 L=0.15 m=1
XN_t3 vdd db_t3 s_t3 vss sky130_fd_pr__nfet_01v8 W=1.68 L=0.15 m=1
XC_t4 s_t4 cbias c_t4 vss sky130_fd_pr__nfet_01v8 W=13.44 L=0.5 m=2
XP_t4 outp d_t4 s_t4 vss sky130_fd_pr__nfet_01v8 W=1.68 L=0.15 m=1
XN_t4 vdd db_t4 s_t4 vss sky130_fd_pr__nfet_01v8 W=1.68 L=0.15 m=1
XC_t5 s_t5 cbias c_t5 vss sky130_fd_pr__nfet_01v8 W=13.44 L=0.5 m=2
XP_t5 outp d_t5 s_t5 vss sky130_fd_pr__nfet_01v8 W=1.68 L=0.15 m=1
XN_t5 vdd db_t5 s_t5 vss sky130_fd_pr__nfet_01v8 W=1.68 L=0.15 m=1
XC_t6 s_t6 cbias c_t6 vss sky130_fd_pr__nfet_01v8 W=13.44 L=0.5 m=2
XP_t6 outp d_t6 s_t6 vss sky130_fd_pr__nfet_01v8 W=1.68 L=0.15 m=1
XN_t6 vdd db_t6 s_t6 vss sky130_fd_pr__nfet_01v8 W=1.68 L=0.15 m=1
XC_t7 s_t7 cbias c_t7 vss sky130_fd_pr__nfet_01v8 W=13.44 L=0.5 m=2
XP_t7 outp d_t7 s_t7 vss sky130_fd_pr__nfet_01v8 W=1.68 L=0.15 m=1
XN_t7 vdd db_t7 s_t7 vss sky130_fd_pr__nfet_01v8 W=1.68 L=0.15 m=1
XC_t8 s_t8 cbias c_t8 vss sky130_fd_pr__nfet_01v8 W=13.44 L=0.5 m=2
XP_t8 outp d_t8 s_t8 vss sky130_fd_pr__nfet_01v8 W=1.68 L=0.15 m=1
XN_t8 vdd db_t8 s_t8 vss sky130_fd_pr__nfet_01v8 W=1.68 L=0.15 m=1
XC_t9 s_t9 cbias c_t9 vss sky130_fd_pr__nfet_01v8 W=13.44 L=0.5 m=2
XP_t9 outp d_t9 s_t9 vss sky130_fd_pr__nfet_01v8 W=1.68 L=0.15 m=1
XN_t9 vdd db_t9 s_t9 vss sky130_fd_pr__nfet_01v8 W=1.68 L=0.15 m=1
XC_t10 s_t10 cbias c_t10 vss sky130_fd_pr__nfet_01v8 W=13.44 L=0.5 m=2
XP_t10 outp d_t10 s_t10 vss sky130_fd_pr__nfet_01v8 W=1.68 L=0.15 m=1
XN_t10 vdd db_t10 s_t10 vss sky130_fd_pr__nfet_01v8 W=1.68 L=0.15 m=1
XC_t11 s_t11 cbias c_t11 vss sky130_fd_pr__nfet_01v8 W=13.44 L=0.5 m=2
XP_t11 outp d_t11 s_t11 vss sky130_fd_pr__nfet_01v8 W=1.68 L=0.15 m=1
XN_t11 vdd db_t11 s_t11 vss sky130_fd_pr__nfet_01v8 W=1.68 L=0.15 m=1
XC_t12 s_t12 cbias c_t12 vss sky130_fd_pr__nfet_01v8 W=13.44 L=0.5 m=2
XP_t12 outp d_t12 s_t12 vss sky130_fd_pr__nfet_01v8 W=1.68 L=0.15 m=1
XN_t12 vdd db_t12 s_t12 vss sky130_fd_pr__nfet_01v8 W=1.68 L=0.15 m=1
XC_t13 s_t13 cbias c_t13 vss sky130_fd_pr__nfet_01v8 W=13.44 L=0.5 m=2
XP_t13 outp d_t13 s_t13 vss sky130_fd_pr__nfet_01v8 W=1.68 L=0.15 m=1
XN_t13 vdd db_t13 s_t13 vss sky130_fd_pr__nfet_01v8 W=1.68 L=0.15 m=1
XC_t14 s_t14 cbias c_t14 vss sky130_fd_pr__nfet_01v8 W=13.44 L=0.5 m=2
XP_t14 outp d_t14 s_t14 vss sky130_fd_pr__nfet_01v8 W=1.68 L=0.15 m=1
XN_t14 vdd db_t14 s_t14 vss sky130_fd_pr__nfet_01v8 W=1.68 L=0.15 m=1
XC_b5 s_b5 cbias c_b5 vss sky130_fd_pr__nfet_01v8 W=6.72 L=0.5 m=2
XP_b5 outp d_b5 s_b5 vss sky130_fd_pr__nfet_01v8 W=0.84 L=0.15 m=1
XN_b5 vdd db_b5 s_b5 vss sky130_fd_pr__nfet_01v8 W=0.84 L=0.15 m=1
XC_b4 s_b4 cbias c_b4 vss sky130_fd_pr__nfet_01v8 W=3.36 L=0.5 m=2
XP_b4 outp d_b4 s_b4 vss sky130_fd_pr__nfet_01v8 W=0.42 L=0.15 m=1
XN_b4 vdd db_b4 s_b4 vss sky130_fd_pr__nfet_01v8 W=0.42 L=0.15 m=1
XC_b3 s_b3 cbias c_b3 vss sky130_fd_pr__nfet_01v8 W=1.68 L=0.5 m=2
XP_b3 outp d_b3 s_b3 vss sky130_fd_pr__nfet_01v8 W=0.42 L=0.15 m=1
XN_b3 vdd db_b3 s_b3 vss sky130_fd_pr__nfet_01v8 W=0.42 L=0.15 m=1
XC_b2 s_b2 cbias c_b2 vss sky130_fd_pr__nfet_01v8 W=0.84 L=0.5 m=2
XP_b2 outp d_b2 s_b2 vss sky130_fd_pr__nfet_01v8 W=0.42 L=0.15 m=1
XN_b2 vdd db_b2 s_b2 vss sky130_fd_pr__nfet_01v8 W=0.42 L=0.15 m=1
XC_b1 s_b1 cbias c_b1 vss sky130_fd_pr__nfet_01v8 W=0.42 L=0.5 m=2
XP_b1 outp d_b1 s_b1 vss sky130_fd_pr__nfet_01v8 W=0.42 L=0.15 m=1
XN_b1 vdd db_b1 s_b1 vss sky130_fd_pr__nfet_01v8 W=0.42 L=0.15 m=1
XC_b0 s_b0 cbias c_b0 vss sky130_fd_pr__nfet_01v8 W=0.42 L=0.5 m=2
XP_b0 outp d_b0 s_b0 vss sky130_fd_pr__nfet_01v8 W=0.42 L=0.15 m=1
XN_b0 vdd db_b0 s_b0 vss sky130_fd_pr__nfet_01v8 W=0.42 L=0.15 m=1
* offset segments: always into outp, through a cascode like the rest
XC_o0 outp cbias c_o0 vss sky130_fd_pr__nfet_01v8 W=13.44 L=0.5 m=2
XC_o1 outp cbias c_o1 vss sky130_fd_pr__nfet_01v8 W=13.44 L=0.5 m=2
XC_o2 outp cbias c_o2 vss sky130_fd_pr__nfet_01v8 W=5.46 L=0.5 m=2
.ends
