* sarfe -- LVS reference for layout/sarfe.gds, generated by fe_netlist.py
.subckt sarfe vdd vss outp outn rs vg s1_n s2_n cmp_clk cmp_p cmp_n vp vn bpos0 bpos1 bpos2 bpos3 bpos4 bpos5 bneg0 bneg1 bneg2 bneg3 bneg4 bneg5 bmid0 bmid1 bmid2 bmid3 bmid4 bmid5 vrp20 vrp10 vrp5 vrm vrn5 vrn10 vrn20
* encode switches: transmission gates
XS1p outp s1_n vp vdd sky130_fd_pr__pfet_01v8 W=5 L=0.15
XS1n outn s1_n vn vdd sky130_fd_pr__pfet_01v8 W=5 L=0.15
XS1pn outp s1 vp vss sky130_fd_pr__nfet_01v8_lvt W=5 L=0.15
XIs1p s1 s1_n vdd vdd sky130_fd_pr__pfet_01v8 W=2 L=0.15
XIs1n s1 s1_n vss vss sky130_fd_pr__nfet_01v8 W=1 L=0.15
* the ramp switch: current steering, gate bias tracking the corner
XSr vn g rs vss sky130_fd_pr__nfet_01v8 W=5 L=0.15 m=2
XSd vdd gb rs vss sky130_fd_pr__nfet_01v8 W=5 L=0.15 m=2
XDp1 g s2_n vg vdd sky130_fd_pr__pfet_01v8 W=2 L=0.15
XDn1 g s2_n vss vss sky130_fd_pr__nfet_01v8 W=0.5 L=0.15
XDp2 gb g vg vdd sky130_fd_pr__pfet_01v8 W=2 L=0.15
XDn2 gb g vss vss sky130_fd_pr__nfet_01v8 W=0.5 L=0.15
XRs vg vg m vss sky130_fd_pr__nfet_01v8 W=1 L=0.15
XRd m m vss vss sky130_fd_pr__nfet_01v8 W=4.5 L=0.5 m=4
XCg vss vg vss vss sky130_fd_pr__nfet_01v8 W=20 L=5 m=2
* CDAC: fixed part, top plate to the side, bottom to vss
XCfp vp vss sky130_fd_pr__cap_mim_m3_1 W=12.62 L=12.62
XCfn vn vss sky130_fd_pr__cap_mim_m3_1 W=12.62 L=12.62
* switched weights: MIM units, three-state bottom plates
* weight 1: 1 unit(s), taps vrp5/vrn5
XCp0_0 vp bp0 sky130_fd_pr__cap_mim_m3_1 W=2.0 L=2.0
XShp0 bp0 bpos0 vrp5 vss sky130_fd_pr__nfet_01v8 W=0.84 L=0.15
XSlp0 bp0 bneg0 vrn5 vss sky130_fd_pr__nfet_01v8 W=0.84 L=0.15
XSmp0 bp0 bmid0 vrm vss sky130_fd_pr__nfet_01v8 W=0.84 L=0.15
XCn0_0 vn bn0 sky130_fd_pr__cap_mim_m3_1 W=2.0 L=2.0
XShn0 bn0 bneg0 vrp5 vss sky130_fd_pr__nfet_01v8 W=0.84 L=0.15
XSln0 bn0 bpos0 vrn5 vss sky130_fd_pr__nfet_01v8 W=0.84 L=0.15
XSmn0 bn0 bmid0 vrm vss sky130_fd_pr__nfet_01v8 W=0.84 L=0.15
* weight 2: 1 unit(s), taps vrp10/vrn10
XCp1_0 vp bp1 sky130_fd_pr__cap_mim_m3_1 W=2.0 L=2.0
XShp1 bp1 bpos1 vrp10 vss sky130_fd_pr__nfet_01v8 W=0.84 L=0.15
XSlp1 bp1 bneg1 vrn10 vss sky130_fd_pr__nfet_01v8 W=0.84 L=0.15
XSmp1 bp1 bmid1 vrm vss sky130_fd_pr__nfet_01v8 W=0.84 L=0.15
XCn1_0 vn bn1 sky130_fd_pr__cap_mim_m3_1 W=2.0 L=2.0
XShn1 bn1 bneg1 vrp10 vss sky130_fd_pr__nfet_01v8 W=0.84 L=0.15
XSln1 bn1 bpos1 vrn10 vss sky130_fd_pr__nfet_01v8 W=0.84 L=0.15
XSmn1 bn1 bmid1 vrm vss sky130_fd_pr__nfet_01v8 W=0.84 L=0.15
* weight 4: 1 unit(s), taps vrp20/vrn20
XCp2_0 vp bp2 sky130_fd_pr__cap_mim_m3_1 W=2.0 L=2.0
XShp2 bp2 bpos2 vrp20 vss sky130_fd_pr__nfet_01v8 W=0.84 L=0.15
XSlp2 bp2 bneg2 vrn20 vss sky130_fd_pr__nfet_01v8 W=0.84 L=0.15
XSmp2 bp2 bmid2 vrm vss sky130_fd_pr__nfet_01v8 W=0.84 L=0.15
XCn2_0 vn bn2 sky130_fd_pr__cap_mim_m3_1 W=2.0 L=2.0
XShn2 bn2 bneg2 vrp20 vss sky130_fd_pr__nfet_01v8 W=0.84 L=0.15
XSln2 bn2 bpos2 vrn20 vss sky130_fd_pr__nfet_01v8 W=0.84 L=0.15
XSmn2 bn2 bmid2 vrm vss sky130_fd_pr__nfet_01v8 W=0.84 L=0.15
* weight 8: 2 unit(s), taps vrp20/vrn20
XCp3_0 vp bp3 sky130_fd_pr__cap_mim_m3_1 W=2.0 L=2.0
XCp3_1 vp bp3 sky130_fd_pr__cap_mim_m3_1 W=2.0 L=2.0
XShp3 bp3 bpos3 vrp20 vss sky130_fd_pr__nfet_01v8 W=0.84 L=0.15
XSlp3 bp3 bneg3 vrn20 vss sky130_fd_pr__nfet_01v8 W=0.84 L=0.15
XSmp3 bp3 bmid3 vrm vss sky130_fd_pr__nfet_01v8 W=0.84 L=0.15
XCn3_0 vn bn3 sky130_fd_pr__cap_mim_m3_1 W=2.0 L=2.0
XCn3_1 vn bn3 sky130_fd_pr__cap_mim_m3_1 W=2.0 L=2.0
XShn3 bn3 bneg3 vrp20 vss sky130_fd_pr__nfet_01v8 W=0.84 L=0.15
XSln3 bn3 bpos3 vrn20 vss sky130_fd_pr__nfet_01v8 W=0.84 L=0.15
XSmn3 bn3 bmid3 vrm vss sky130_fd_pr__nfet_01v8 W=0.84 L=0.15
* weight 16: 4 unit(s), taps vrp20/vrn20
XCp4_0 vp bp4 sky130_fd_pr__cap_mim_m3_1 W=2.0 L=2.0
XCp4_1 vp bp4 sky130_fd_pr__cap_mim_m3_1 W=2.0 L=2.0
XCp4_2 vp bp4 sky130_fd_pr__cap_mim_m3_1 W=2.0 L=2.0
XCp4_3 vp bp4 sky130_fd_pr__cap_mim_m3_1 W=2.0 L=2.0
XShp4 bp4 bpos4 vrp20 vss sky130_fd_pr__nfet_01v8 W=1.68 L=0.15
XSlp4 bp4 bneg4 vrn20 vss sky130_fd_pr__nfet_01v8 W=1.68 L=0.15
XSmp4 bp4 bmid4 vrm vss sky130_fd_pr__nfet_01v8 W=1.68 L=0.15
XCn4_0 vn bn4 sky130_fd_pr__cap_mim_m3_1 W=2.0 L=2.0
XCn4_1 vn bn4 sky130_fd_pr__cap_mim_m3_1 W=2.0 L=2.0
XCn4_2 vn bn4 sky130_fd_pr__cap_mim_m3_1 W=2.0 L=2.0
XCn4_3 vn bn4 sky130_fd_pr__cap_mim_m3_1 W=2.0 L=2.0
XShn4 bn4 bneg4 vrp20 vss sky130_fd_pr__nfet_01v8 W=1.68 L=0.15
XSln4 bn4 bpos4 vrn20 vss sky130_fd_pr__nfet_01v8 W=1.68 L=0.15
XSmn4 bn4 bmid4 vrm vss sky130_fd_pr__nfet_01v8 W=1.68 L=0.15
* weight 32: 8 unit(s), taps vrp20/vrn20
XCp5_0 vp bp5 sky130_fd_pr__cap_mim_m3_1 W=2.0 L=2.0
XCp5_1 vp bp5 sky130_fd_pr__cap_mim_m3_1 W=2.0 L=2.0
XCp5_2 vp bp5 sky130_fd_pr__cap_mim_m3_1 W=2.0 L=2.0
XCp5_3 vp bp5 sky130_fd_pr__cap_mim_m3_1 W=2.0 L=2.0
XCp5_4 vp bp5 sky130_fd_pr__cap_mim_m3_1 W=2.0 L=2.0
XCp5_5 vp bp5 sky130_fd_pr__cap_mim_m3_1 W=2.0 L=2.0
XCp5_6 vp bp5 sky130_fd_pr__cap_mim_m3_1 W=2.0 L=2.0
XCp5_7 vp bp5 sky130_fd_pr__cap_mim_m3_1 W=2.0 L=2.0
XShp5 bp5 bpos5 vrp20 vss sky130_fd_pr__nfet_01v8 W=1.68 L=0.15
XSlp5 bp5 bneg5 vrn20 vss sky130_fd_pr__nfet_01v8 W=1.68 L=0.15
XSmp5 bp5 bmid5 vrm vss sky130_fd_pr__nfet_01v8 W=1.68 L=0.15
XCn5_0 vn bn5 sky130_fd_pr__cap_mim_m3_1 W=2.0 L=2.0
XCn5_1 vn bn5 sky130_fd_pr__cap_mim_m3_1 W=2.0 L=2.0
XCn5_2 vn bn5 sky130_fd_pr__cap_mim_m3_1 W=2.0 L=2.0
XCn5_3 vn bn5 sky130_fd_pr__cap_mim_m3_1 W=2.0 L=2.0
XCn5_4 vn bn5 sky130_fd_pr__cap_mim_m3_1 W=2.0 L=2.0
XCn5_5 vn bn5 sky130_fd_pr__cap_mim_m3_1 W=2.0 L=2.0
XCn5_6 vn bn5 sky130_fd_pr__cap_mim_m3_1 W=2.0 L=2.0
XCn5_7 vn bn5 sky130_fd_pr__cap_mim_m3_1 W=2.0 L=2.0
XShn5 bn5 bneg5 vrp20 vss sky130_fd_pr__nfet_01v8 W=1.68 L=0.15
XSln5 bn5 bpos5 vrn20 vss sky130_fd_pr__nfet_01v8 W=1.68 L=0.15
XSmn5 bn5 bmid5 vrm vss sky130_fd_pr__nfet_01v8 W=1.68 L=0.15
* comparator: StrongARM, inputs vn (+) and vp (-)
XMt t cmp_clk vss vss sky130_fd_pr__nfet_01v8 W=4 L=0.15
XM1 x1 vn t vss sky130_fd_pr__nfet_01v8 W=8 L=0.15 m=2
XM2 x2 vp t vss sky130_fd_pr__nfet_01v8 W=8 L=0.15 m=2
XM3 op om x1 vss sky130_fd_pr__nfet_01v8 W=2 L=0.15
XM4 om op x2 vss sky130_fd_pr__nfet_01v8 W=2 L=0.15
XM5 op om vdd vdd sky130_fd_pr__pfet_01v8 W=2 L=0.15
XM6 om op vdd vdd sky130_fd_pr__pfet_01v8 W=2 L=0.15
XMr7 op cmp_clk vdd vdd sky130_fd_pr__pfet_01v8 W=1 L=0.15
XMr8 om cmp_clk vdd vdd sky130_fd_pr__pfet_01v8 W=1 L=0.15
XMr9 x1 cmp_clk vdd vdd sky130_fd_pr__pfet_01v8 W=1 L=0.15
XMr10 x2 cmp_clk vdd vdd sky130_fd_pr__pfet_01v8 W=1 L=0.15
* output buffers: vn > vp discharges op, so cmp_p = not op
XIp1 cmp_p op vdd vdd sky130_fd_pr__pfet_01v8 W=1 L=0.15
XIn1 cmp_p op vss vss sky130_fd_pr__nfet_01v8 W=0.5 L=0.15
XIp2 cmp_n om vdd vdd sky130_fd_pr__pfet_01v8 W=1 L=0.15
XIn2 cmp_n om vss vss sky130_fd_pr__nfet_01v8 W=0.5 L=0.15
.ends
