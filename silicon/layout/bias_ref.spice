* bias -- FDVPD bias block, sky130A.  LVS reference and simulation netlist.
*
* One beta-multiplier reference, mirrored out to everything the detector
* needs.  Absolute accuracy is not the point: the DAC and the ramp both mirror
* from this one current, so their ratio -- the thing that has to be right --
* is mirror ratios times R_D * C_SAR, which the DAC trim takes.  What the
* absolute value does set is the ramp slope, and with it the detector's gain;
* ngspice/bias_tb.py measures that spread.
*
*   iramp   200 uA into the ramp sink's nbias (its reference branch)
*   icbr    200 uA into the ramp sink's cbias (its wide-swing bias device)
*   idac     50 uA into the DAC's ibias (its 128-unit reference diode)
*   dcbias  the DAC cascodes' gate, ~1.30 V, from a replica stack
*   isw      20 uA into the front end's vg: the ramp switch's gate bias
*   vr*     the SAR reference ladder: vrm and taps at +-21.0 / 10.5 / 5.25 mV
*           about it (~0.8 V), for the CDAC's three-state bottom plates
*
* Core: M1 (diode) and M2 (4x, degenerated by Rs) share a gate; the PMOS pair
* M3 / M4 forces equal currents.  I = 2 (1 - 1/sqrt(K))^2 / (uCox (W/L)1 Rs^2).
* Start-up senses CURRENT, not voltage.  Mspd mirrors M1 exactly, so it sinks
* the core's own current, against Mspu's fixed ~5 uA.  Running (25 uA) it wins
* and holds st low, and Msi is off.  Off, or in the low-current state the core
* also has -- about 1.5 uA, which the corners found at tt / -40 C, where n1 is
* already past a threshold -- Mspu wins, st goes high, and Msi pulls the
* PMOS gate to ground until the core climbs out.  Into ground, not into n1: at
* -40 C that version stuck with pg = n1 = 0.61 V, the PMOS 1.19 V below VDD and
* just under its threshold, and Msi holding them there.  (A voltage-sensing start-up
* declared that state "running" and left it there.)

.subckt bias vdd vss iramp icbr idac dcbias vrp20 vrp10 vrp5 vrm vrn5 vrn10 vrn20 isw
* ---- core ------------------------------------------------------------------
XM1 n1 n1 vss vss sky130_fd_pr__nfet_01v8 W=4 L=2
XM2 pg n1 ns vss sky130_fd_pr__nfet_01v8 W=4 L=2 m=4
* drawn as two 8 um halves in parallel: a lone 0.35 um high-sheet resistor
* fails rpm.1 as magic generates it, two share one legal marker
XRs ns vss vss sky130_fd_pr__res_high_po_0p35 L=8.0 m=2
XM3 n1 pg vdd vdd sky130_fd_pr__pfet_01v8 W=8 L=2
XM4 pg pg vdd vdd sky130_fd_pr__pfet_01v8 W=8 L=2
* ---- start-up ----------------------------------------------------------------
XMspu st vss vdd vdd sky130_fd_pr__pfet_01v8 W=0.42 L=3.6
XMspd st n1 vss vss sky130_fd_pr__nfet_01v8 W=4 L=2
XMsi pg st vss vss sky130_fd_pr__nfet_01v8 W=1 L=0.5
* ---- output mirrors (PMOS, gate pg) --------------------------------------------
XMo1 iramp pg vdd vdd sky130_fd_pr__pfet_01v8 W=8 L=2 m=8
XMo2 icbr  pg vdd vdd sky130_fd_pr__pfet_01v8 W=8 L=2 m=8
XMo3 idac  pg vdd vdd sky130_fd_pr__pfet_01v8 W=8 L=2 m=2
XMo6 isw   pg vdd vdd sky130_fd_pr__pfet_01v8 W=3.2 L=2 m=2
* ---- DAC cascode bias: 5 uA into a replica stack ------------------------------
* top: the DAC cascode's density (0.42 um per 390 nA) at 5 uA, so its Vgs is
* the cascode's; bottom: a small diode standing in for the unit's Vds target
XMo4 dcbias pg vdd vdd sky130_fd_pr__pfet_01v8 W=1.6 L=2
XMcr dcbias dcbias ncb vss sky130_fd_pr__nfet_01v8 W=5.4 L=0.5
XMcb ncb ncb vss vss sky130_fd_pr__nfet_01v8 W=5 L=CBL m=CBM
* ---- SAR reference ladder: 10 uA down 16 identical units, parked by a diode
* taps (units of 2.625 mV below the top): 0, 4, 6, 8, 10, 12, 16 -- i.e. the
* middle (vrm) and +-21.0, +-10.5, +-5.25 mV about it.  Identical units in
* series keep the ratios exact whatever the contact resistance is.
XMo5 vrp20 pg vdd vdd sky130_fd_pr__pfet_01v8 W=3.2 L=2
XRl0 vrp20 l1 sky130_fd_pr__res_generic_po W=1 L=RLAD
XRl1 l1 l2 sky130_fd_pr__res_generic_po W=1 L=RLAD
XRl2 l2 l3 sky130_fd_pr__res_generic_po W=1 L=RLAD
XRl3 l3 vrp10 sky130_fd_pr__res_generic_po W=1 L=RLAD
XRl4 vrp10 l5 sky130_fd_pr__res_generic_po W=1 L=RLAD
XRl5 l5 vrp5 sky130_fd_pr__res_generic_po W=1 L=RLAD
XRl6 vrp5 l7 sky130_fd_pr__res_generic_po W=1 L=RLAD
XRl7 l7 vrm sky130_fd_pr__res_generic_po W=1 L=RLAD
XRl8 vrm l9 sky130_fd_pr__res_generic_po W=1 L=RLAD
XRl9 l9 vrn5 sky130_fd_pr__res_generic_po W=1 L=RLAD
XRl10 vrn5 l11 sky130_fd_pr__res_generic_po W=1 L=RLAD
XRl11 l11 vrn10 sky130_fd_pr__res_generic_po W=1 L=RLAD
XRl12 vrn10 l13 sky130_fd_pr__res_generic_po W=1 L=RLAD
XRl13 l13 l14 sky130_fd_pr__res_generic_po W=1 L=RLAD
XRl14 l14 l15 sky130_fd_pr__res_generic_po W=1 L=RLAD
XRl15 l15 vrn20 sky130_fd_pr__res_generic_po W=1 L=RLAD
XMlb vrn20 vrn20 vss vss sky130_fd_pr__nfet_01v8 W=4 L=1
.ends
